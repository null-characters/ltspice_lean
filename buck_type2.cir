*Buck Converter - Type-II Compensation (Closed Loop)
*50kHz PWM, duty from Type-II compensator, e = Vref - Vout
*Vref steps 6V->8V at 10ms. Clamp duty 0~100%.
*Type-II: fc=150Hz(运放稳定上限), fz=1592Hz(LC), fp=1751Hz(1.1xf0), G0=933
*设计: type2_design.py 100u 100u 10 150 --fz 1592 --fp 1751

Vin in 0 12

*=== Type-II Duty-Cycle Controller (op-amp implementation) ===
*Gc(s) = (1+sR2Cf1) / (sRin(Cf1+Cf2)(1+sR2Cf1Cf2/(Cf1+Cf2)))
*  fz = 1/(2πR2Cf1) = 1592Hz (LC 谐振，零点补偿)
*  fp = 1/(2πR2·Cf1Cf2/(Cf1+Cf2)) = 1751Hz (1.1×f0，紧贴 f0 压低谐振峰防第二穿越)
*  积分极点 s=0：消除静差
*Carrier: sawtooth 0~12V, period 20us (50kHz), duty = V(vop)/12
*PULSE(V1 V2 Td Trise Tfall Ton Tperiod): 19.6u rise + 0.2u hold + 0.2u fall = 20u
Vtri tri 0 PULSE(0 12 0 19.6u 0.2u 0.2u 20u)
*Reference: 6V, ramps to 8V over 0.1ms starting at 10ms, then holds
Bref ref 0 V=6+2*limit((time-50m)/0.1m,0,1)
*Error: negative error e = Vout - Vref (op-amp inverting makes it positive)
Berr err 0 V=V(out)-V(ref)
*Type-II op-amp compensator:
*  Rin: input, feedback = (R2+C1 series) || C2
Rin err vn 9.73k
R2 vop vm 10.00k
Cf1 vm vn 10.00n
Cf2 vop vn 100.13n
*Ideal op-amp (inverting, gain 1e6, output clamped)
Eop vop 0 VALUE={limit(-1e6*V(vn), -15, 15)}
*PWM compare: on when carrier < duty command
Bpwm pwm 0 V=if(V(tri)<V(vop), 12, 0)

*=== Bootstrap Circuit ===
*Vcc supplies bootstrap capacitor through diode Db
Vcc vcc 0 12
Db vcc boot D
*Bootstrap capacitor: bottom plate tied to sw node
Cb boot sw 100n
*DC path for boot node (avoid floating node in .op analysis)
Rboot boot 0 1meg

*=== Gate Driver (models bootstrap-driven driver chip) ===
*Bootstrap keeps Vgs constant: Vgs = Vboot-Vsw = ~11.5V when PWM high
*Driver output = V(sw) + Vgs_drive, independent of V(boot) to avoid feedback loop
B1 drv 0 V=V(sw)+if(V(pwm)>6, 11.5, 0)
*Driver output impedance (like a real driver chip)
Rg drv gate 10
*Gate capacitance (real MOSFET has Cgs)
Cg gate sw 1n
*Convergence aid: breaks algebraic loop sw->gate->sw (needed with L=100u)
Cgnd gate 0 1n

*=== Power Stage ===
*NMOS Switch - Drain to Vin, Source to sw node
M1 in gate sw 0 NMOS
*Freewheeling Diode - Cathode to sw, Anode to GND
D1 0 sw D
*DC path for sw node (avoid floating node in .op analysis)
Rsw sw 0 10meg
*Inductor - sw node to output
L1 sw out 100u
*Output Capacitor
C1 out 0 100u
*Load Resistor
R1 out 0 10

*=== Models ===
.MODEL NMOS NMOS(VTO=2 KP=10)
.MODEL D D(IS=1e-12)

*Transient Analysis (uic: skip .op, start from zero state)
.tran 150ms uic

*=== Measurements ===
*Before ref step (2~9.9ms): Vref=6V
.meas Vout_before AVG V(out) TRIG time=30ms TARG time=49.9ms
.meas Dctrl_before AVG V(vop) TRIG time=30ms TARG time=49.9ms
.meas Duty_before AVG V(vop)*100/12 TRIG time=30ms TARG time=49.9ms
*Duty ramp after ref step (10ms Vref 6->8V): track dctrl over time
*Duty cycle = V(vop)/12 * 100%
.meas Dctrl_t1 AVG V(vop) TRIG time=60ms TARG time=70ms
.meas Duty_t1 AVG V(vop)*100/12 TRIG time=60ms TARG time=70ms
.meas Dctrl_t2 AVG V(vop) TRIG time=70ms TARG time=80ms
.meas Duty_t2 AVG V(vop)*100/12 TRIG time=70ms TARG time=80ms
.meas Dctrl_t3 AVG V(vop) TRIG time=80ms TARG time=90ms
.meas Duty_t3 AVG V(vop)*100/12 TRIG time=80ms TARG time=90ms
.meas Dctrl_t4 AVG V(vop) TRIG time=90ms TARG time=100ms
.meas Duty_t4 AVG V(vop)*100/12 TRIG time=90ms TARG time=100ms
.meas Dctrl_t5 AVG V(vop) TRIG time=100ms TARG time=110ms
.meas Duty_t5 AVG V(vop)*100/12 TRIG time=100ms TARG time=110ms
*Step response window (50~90ms): overshoot / undershoot after Vref step
.meas Vout_step_min MIN V(out) TRIG time=50.1ms TARG time=90ms
.meas Vout_step_max MAX V(out) TRIG time=50.1ms TARG time=90ms
*After ref step (90~150ms): Vref=8V
.meas Vout_after AVG V(out) TRIG time=90ms TARG time=150ms
.meas Dctrl_after AVG V(vop) TRIG time=90ms TARG time=150ms
.meas Duty_after AVG V(vop)*100/12 TRIG time=90ms TARG time=150ms
.meas Vout_min MIN V(out) TRIG time=90ms TARG time=150ms
.meas Vout_max MAX V(out) TRIG time=90ms TARG time=150ms
*IL after step
.meas IL_after AVG I(L1) TRIG time=90ms TARG time=150ms
*Mode check: IL_min > 0 -> CCM, IL_min ~ 0 -> DCM
.meas IL_min_after MIN I(L1) TRIG time=90ms TARG time=150ms
.meas IL_max_after MAX I(L1) TRIG time=90ms TARG time=150ms

.end
