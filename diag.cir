*Buck Converter - Diagnosis
*Diagnose why Vout != Vin*D

*=== Circuit ===
Vin in 0 12
Vgate gate 0 PULSE(0 20 0 10n 10n 5u 10u)
M1 in gate sw 0 NMOS
D1 0 sw D
L1 sw out 10u
C1 out 0 100u
R1 out 0 1

*=== Models ===
.MODEL NMOS NMOS(VTO=2 KP=10)
.MODEL D D(IS=1e-12)

*=== Transient Analysis ===
.tran 10ms

*=== Measurements ===
.meas Vout_avg AVG V(out) TRIG time=5ms TARG time=10ms
.meas Vin_avg AVG V(in) TRIG time=5ms TARG time=10ms
.meas Vsw_avg AVG V(sw) TRIG time=5ms TARG time=10ms
.meas Vsw_max MAX V(sw) TRIG time=5ms TARG time=10ms
.meas Vsw_min MIN V(sw) TRIG time=5ms TARG time=10ms
.meas Vgs_max MAX V(gate)-V(sw) TRIG time=5ms TARG time=10ms
.meas Vgs_min MIN V(gate)-V(sw) TRIG time=5ms TARG time=10ms
.meas Vd_max MAX V(sw) TRIG time=5ms TARG time=10ms
.meas IL_avg AVG I(L1) TRIG time=5ms TARG time=10ms
.meas ID1_avg AVG I(D1) TRIG time=5ms TARG time=10ms
.meas IM1_avg AVG I(M1) TRIG time=5ms TARG time=10ms
.meas VD_avg AVG -V(sw) TRIG time=5ms TARG time=10ms

.end
